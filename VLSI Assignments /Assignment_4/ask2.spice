.include ./technology.txt
.global vdd
.param supply=2.5

*inverter subcircuit

.subckt inv in out params: wn=3u wp=9u
MPMOS out in vdd vdd CMOSP w=wn l=2u
MNMOS out in 0 0 CMOSN w=wp l=2u
.ends

*transmission gate cmos

.subckt passgate en nen in out params: wn=3u wp=9u
MNMOS out nen in 0 CMOSN w=wn l=2u
MPMOS in en out vdd CMOSP w=wp l=2u
.ends

*ulopoisi ton 4 antistrofeon se seira
Xinvg1 clk outg1 inv params: wn=3u wp=9u
Xinvg1_1 outg1 outg1_1 inv params: wn=3u wp=9u
Xinvg2 outg1_1 outg2 inv params: wn=6u wp=18u
Xinvg3 outg2 outg3 inv params: wn=12u wp=36u

*circuit that makes Qm
.ic v(outT1T2)=2.5v
XinvD d nd inv params: wn=3u wp=9u
XpassgateT1 outg2 outg3 nd outT1T2 passgate params: wn=3u wp=9u
XinvT1T2 outT1T2 QM inv params: wn=3u wp=9u
XinvQM QM inT2 inv params: wn=3u wp=9u
XpassgateT2 outg3 outg2 inT2 outT1T2 passgate params: wn=3u wp=9u

*circuit that makes the Q
.ic v(outT3T4)=2.5v
XinvI4 QM inT3 inv params: wn=3u wp=9u
XpassgateT3 outg3 outg2 inT3 outT3T4 passgate params:wn=3u wp=9u
XinvT3T4 outT3T4 Q inv params: wn=3u wp=9u
XinvI5 Q inT4 inv params: wn=3u wp=9u
XpassgateT4 outg2 outg3 inT4 outT3T4 passgate params:wn=3u wp=9u

Cq Q 0 0.2p

*vclk clk 0 pulse(2.5 0 0n  200p 200p 15n 30n)
*vd d 0 pulse(0 2.5 15n  200p 400p 30n 60n)

vclk clk 0 pulse(2.5 0 3n  200p 200p 50n 100n)
vd d 0 pulse(0 2.5 100n  400p 400p 100n 200n)

vvdd vdd 0 2.5v dc

*xronos anodou kai kathodou tis Qm

.meas tran T_rise
+ trig v(QM) val=0.25 rise=1
+ targ v(QM) val=2.25 rise=1

.meas tran T_fall
+ trig v(QM) val=2.25 fall=1
+targ v(QM) val=0.25 fall=1

*xronos anodou kai kathodou tis q

.meas tran T_rise
+ trig v(Q) val=0.25 rise=1
+ targ v(Q) val=2.25 rise=1

.meas tran T_fall
+ trig v(Q) val=2.25 fall=1
+targ v(Q) val=0.25 fall=1

*set up time

.meas tran T_setup
+ trig v(d) val=1.25 rise=1
+ targ v(clk) val=1.25 fall=2

*.meas tran T_fall
*+ trig v(Q) val=2.25 fall=1
*+targ v(Q) val=0.25 fall=1

*hold time

.meas tran T_hold

+ trig v(clk) val=1.25 fall=2
+targ v(d) val=1.25 fall=1

.tran 10p 400n

.control
run
set color0=white
plot   clk d q
*plot outg2
*plot outg3
*plot inT2
*plot nd
*plot outT1T2
*plot d
*plot QM
*plot inT3
*plot outT3T4
*plot outT1T2
*plot inT3
*plot clk
*plot q
*plot d
.endc

.end
