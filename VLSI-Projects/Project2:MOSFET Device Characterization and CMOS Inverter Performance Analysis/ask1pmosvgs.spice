.include ./technology.txt

Vgs  1 0 DC -2.5
Vds 2 0  DC -2.5
MPMOS  2 1 0 0 CMOSP W=3u L=2u

.DC  Vgs -2.5 0 0.25 Vds -2.5 0 0.25
.control
	run
	set color0=black
	set color1=blue
	plot (-i(Vds))
.endc
.end
