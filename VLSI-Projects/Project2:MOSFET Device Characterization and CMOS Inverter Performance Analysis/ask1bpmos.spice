.include ./technology.txt

Vdd 3 0 DC 2.5
Vgs  1 3  DC -2.5
C1 2 0 0.1p
MPMOS 2 1 3 3 CMOSP W=3u L=2u

.IC v(2)=0
.measure tran tp WHEN v(2)=1.25 CROSS=1
.tran 1n 100n
.control
	run
	set color0=white
	set color1=blue
	plot V(2) 1.25

.endc
.end
