.include ./technology.txt

Vin 1 0 DC 0
M1 2 1 0 0 CMOSP W=3u L=2u
M2 4 1 2 0 CMOSP W=3u L=2u
C1 4 0 0.1p

.IC V(4)=2.5
.IC V(2)=2.5
.tran 10p 2n

.control
	run
	set color0=white
	set color1=black
	plot V(2) V(4) V(1)

.endc
.end
