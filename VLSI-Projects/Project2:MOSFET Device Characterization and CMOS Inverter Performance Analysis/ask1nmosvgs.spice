.include ./technology.txt

Vds  2 0 DC 2.5
Vgs  1 0 DC 2.5
MNMOS 2 1 0 0 CMOSN W=3u L=2u

.DC  Vgs 0 2.2.5 0.25 Vds 0 2.5 0.25
.control
	set color0=black
	set color1=blue
	run
	plot (-i(Vds))
.endc
.end
