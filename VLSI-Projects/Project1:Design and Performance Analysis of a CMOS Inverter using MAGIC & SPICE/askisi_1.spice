* SPICE3 file ireated from /root/lab1/askisi_1.ext - technology: scmos

.option scale=1u
.include ./technology.txt
.param supply 2.5

Vpower vdd gnd 2.5 DC

Vin in gnd PWL(0 0 175p 0  425p 2.5 1000p 2.5 1250p 0 )
*Vin in gnd PWL(0 0 75p 0 325p 2.5  925p 2.5 1175p 0)
MP0 out in gnd gnd CMOSN w=3 l=2
+  ad=19 pd=18 as=19 ps=18
MN0 out in vdd vdd CMOSP w=3 l=2
+  ad=19 pd=18 as=19 ps=18
C0 in 0 3.64fF

*a erotima

.meas tran T_phl
+ trig v(in) val=0.5*supply rise=1
+ targ v(out) val=0.5*supply fall=1

.meas tran T_plh
+ trig v(in) val=0.5*supply fall=1
+ targ v(out) val=0.5*supply rise=1

*b erotima

.meas tran T_rise
+ trig v(out) val=0.1*supply rise=1
+ targ v(out) val=0.9*supply rise=1

.meas tran T_fall
+ trig v(out) val=0.9*supply fall=1
+targ v(out) val=0.1*supply fall=1

.tran 10p 7000p
.control
run
plot in out
.endc
.end
