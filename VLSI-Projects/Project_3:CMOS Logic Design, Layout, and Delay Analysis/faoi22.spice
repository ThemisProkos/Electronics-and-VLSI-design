* SPICE3 file created from /root/lab3/faoi22.ext - technology: scmos

.option scale=1u

Vpower vdd gnd 2.5 DC

M1000 K1 inC Vdd Vdd pfet w=19 l=2
+  ad=304 pd=146 as=114 ps=50
M1001 gnd inC K2 gnd nfet w=8 l=2
+  ad=48 pd=28 as=48 ps=28
M1002 Vdd inA K1 Vdd pfet w=19 l=2
+  ad=0 pd=0 as=0 ps=0
M1003 K2 inA out gnd nfet w=8 l=2
+  ad=0 pd=0 as=80 ps=52
M1004 K1 inB out Vdd pfet w=19 l=2
+  ad=0 pd=0 as=114 ps=50
M1005 out inD K1 Vdd pfet w=19 l=2
+  ad=0 pd=0 as=0 ps=0
M1006 out inB K3 gnd nfet w=8 l=2
+  ad=0 pd=0 as=48 ps=28
M1007 K3 inD gnd gnd nfet w=8 l=2
+  ad=0 pd=0 as=0 ps=0
C0 gnd inD 5.08fF
C1 Vdd inB 3.10fF
C2 K1 Vdd 9.78fF
C3 gnd inA 5.08fF
C4 gnd inB 5.08fF
C5 Vdd inC 3.10fF
C6 Vdd inD 3.10fF
C7 Vdd inA 3.10fF
C8 gnd inC 5.08fF
C9 out 0 8.86fF
C10 inB 0 2.46fF
C11 inD 0 2.46fF
C12 inC 0 2.46fF
C13 inA 0 2.46fF

*edo tha ginetai i allagi ton timon eisodou gia na epalitheusoume ton pinaka alithias tis sinartisis
Vin1 inA 0 PULSE(2.5 0 0 1p 1p 100n 200n)
Vin2 inB 0 PULSE(2.5 0 0 1p 1p 50n 100n)
Vin3 inC 0 PULSE(2.5 0 0 1p 1p 25n 50n)
Vin4 inD 0 PULSE(2.5 0 0 1p 1p 12.5n 25n)

* DATE: Jun 11/01
* LOT: T14Y                  WAF: 03
* DIE: N_Area_Fring          DEV: N3740/10
* Temp= 27
.MODEL nfet NMOS (                                 LEVEL  = 3
+ TOX    = 5.7E-9          NSUB   = 1E17            GAMMA  = 0.4317311
+ PHI    = 0.7             VTO    = 0.4238252       DELTA  = 0
+ UO     = 425.6466519     ETA    = 0               THETA  = 0.1754054
+ KP     = 2.501048E-4     VMAX   = 8.287851E4      KAPPA  = 0.1686779
+ RSH    = 4.062439E-3     NFS    = 1E12            TPG    = 1
+ XJ     = 3E-7            LD     = 3.162278E-11    WD     = 1.232881E-8
+ CGDO   = 6.2E-10         CGSO   = 6.2E-10         CGBO   = 1E-10
+ CJ     = 1.81211E-3      PB     = 0.5             MJ     = 0.3282553
+ CJSW   = 5.341337E-10    MJSW   = 0.5             )

.MODEL pfet PMOS (                                 LEVEL  = 3
+ TOX    = 5.7E-9          NSUB   = 1E17            GAMMA  = 0.6348369
+ PHI    = 0.7             VTO    = -0.5536085      DELTA  = 0
+ UO     = 250             ETA    = 0               THETA  = 0.1573195
+ KP     = 5.194153E-5     VMAX   = 2.295325E5      KAPPA  = 0.7448494
+ RSH    = 30.0776952      NFS    = 1E12            TPG    = -1
+ XJ     = 2E-7            LD     = 9.968346E-13    WD     = 5.475113E-9
+ CGDO   = 6.66E-10        CGSO   = 6.66E-10        CGBO   = 1E-10
+ CJ     = 1.893569E-3     PB     = 0.9906013       MJ     = 0.4664287
+ CJSW   = 3.625544E-10    MJSW   = 0.5             )
*

.tran 10p 200n
.control
 run
plot V(inA) V(inB) V(inC) V(inD) out

.endc
.end
