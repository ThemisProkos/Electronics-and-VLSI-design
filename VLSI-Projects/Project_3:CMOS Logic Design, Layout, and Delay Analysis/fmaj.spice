* SPICE3 file created from fmaj.ext - technology: scmos

.option scale=1u

Vpower vdd gnd 2.5 DC

M1000 Vdd inB K1 Vdd pfet w=38 l=2
+  ad=209 pd=88 as=228 ps=88
M1001 K1 inC K2 Vdd pfet w=38 l=2
+  ad=0 pd=0 as=399 ps=184
M1002 K2 inA Vdd Vdd pfet w=19 l=2
+  ad=0 pd=0 as=0 ps=0
M1003 out inC K2 Vdd pfet w=19 l=2
+  ad=114 pd=50 as=0 ps=0
M1004 gnd inA K4 gnd nfet w=8 l=2
+  ad=48 pd=28 as=88 ps=54
M1005 K4 inB out gnd nfet w=8 l=2
+  ad=0 pd=0 as=88 ps=54
M1006 K2 inB out Vdd pfet w=19 l=2
+  ad=0 pd=0 as=0 ps=0
M1007 out inC K4 gnd nfet w=8 l=2
+  ad=0 pd=0 as=0 ps=0
M1008 K3 inC gnd gnd nfet w=8 l=2
+  ad=48 pd=28 as=0 ps=0
M1009 out inB K3 gnd nfet w=8 l=2
+  ad=0 pd=0 as=0 ps=0
C0 Vdd inA 7.62fF
C1 gnd K4 4.51fF
C2 gnd inC 14.13fF
C3 gnd inB 14.13fF
C4 Vdd K2 14.48fF
C5 gnd inA 7.06fF
C6 Vdd out 5.26fF
C7 Vdd inC 10.72fF
C8 Vdd inB 10.72fF
C9 out 0 9.36fF
C10 inB 0 4.28fF
C11 inC 0 4.28fF
C12 inA 0 2.14fF

*edo tha ginetai i allagi ton timon eisodou gia na epalitheusoume ton pinaka alithias tis sinartisis
Vin1 inA 0 PULSE(2.5 0 0 1p 1p 50n 100n)
Vin2 inB 0 PULSE(2.5 0 0 1p 1p 25n 50n)
Vin3 inC 0 PULSE(2.5 0 0 1p 1p 12.5n 25n)

* DATE: Jun 11/01
* LOT: T14Y                  WAF: 03
* DIE: N_Area_Fring          DEV: N3740/10
* Temp= 27
.MODEL nfet NMOS (                                 LEVEL  = 3
+ TOX    = 5.7E-9          NSUB   = 1E17            GAMMA  = 0.4317311
+ PHI    = 0.7             VTO    = 0.4238252       DELTA  = 0
+ UO     = 425.6466519     ETA    = 0               THETA  = 0.1754054
+ KP     = 2.501048E-4     VMAX   = 8.287851E4      KAPPA  = 0.1686779
+ RSH    = 4.062439E-3     NFS    = 1E12            TPG    = 1
+ XJ     = 3E-7            LD     = 3.162278E-11    WD     = 1.232881E-8
+ CGDO   = 6.2E-10         CGSO   = 6.2E-10         CGBO   = 1E-10
+ CJ     = 1.81211E-3      PB     = 0.5             MJ     = 0.3282553
+ CJSW   = 5.341337E-10    MJSW   = 0.5             )

.MODEL pfet PMOS (                                 LEVEL  = 3
+ TOX    = 5.7E-9          NSUB   = 1E17            GAMMA  = 0.6348369
+ PHI    = 0.7             VTO    = -0.5536085      DELTA  = 0
+ UO     = 250             ETA    = 0               THETA  = 0.1573195
+ KP     = 5.194153E-5     VMAX   = 2.295325E5      KAPPA  = 0.7448494
+ RSH    = 30.0776952      NFS    = 1E12            TPG    = -1
+ XJ     = 2E-7            LD     = 9.968346E-13    WD     = 5.475113E-9
+ CGDO   = 6.66E-10        CGSO   = 6.66E-10        CGBO   = 1E-10
+ CJ     = 1.893569E-3     PB     = 0.9906013       MJ     = 0.4664287
+ CJSW   = 3.625544E-10    MJSW   = 0.5             )
*

.tran 10p 100n
.control
 run
plot V(inA) V(inB) V(inC)  out

.endc
.end
