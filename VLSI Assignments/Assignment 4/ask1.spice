.include ./technology.txt
.global vdd
.option scale=1u

*inverter subcircuit

.subckt inv in out params: wn=3 wp=9
MPMOS out in vdd vdd CMOSP w=wp l=2
MNMOS out in 0 0 CMOSN w=wn l=2
.ends

*transmission gate cmos

.subckt passgate en nen in out params: wn=3 wp=9
MNMOS out nen in 0 CMOSN w=wn l=2
MPMOS in en out vdd CMOSP w=wp l=2
.ends

*"small and big not gates" circuit

.subckt smallandbiginverter in out
Xi1 in out inv params: wn=10 wp=30
Xi2 out in inv params: wn=3 wp=9
.ends

.ic v(ndpass)=0v

*creating not clk
Xnclk clk nclk inv params: wn=3 wp=9

*1os antistofeas me eisodo D
XinvD d nd inv params: wn=10 wp=30

*calling the trasmission gate

Xpassgate clk nclk nd ndpass passgate params: wn=9 wp=9

*calling the small and big not gates circuit

Xs ndpass q smallandbiginverter

vvdd vdd 0 2.5v dc
*Vdd 1 0 2.5v dc

vd d 0 pulse(2.5 0 0 1p 1p 50n 100n)
vclk clk 0 pulse(2.5 0 0 1p 1p 100n 200n)
.tran 10p 400n

.control
run
set color0=white
plot d clk q
*plot nd
*plot ndpass
*plot q
*plot clk
.endc

.end
