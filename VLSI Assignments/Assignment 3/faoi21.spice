* SPICE3 file created from faoi21.ext - technology: scmos

.option scale=1u

Vpower vdd gnd 2.5 DC

M1000 K2 inB out Gnd nfet w=8 l=2
+  ad=48 pd=28 as=44 ps=28
M1001 K1 inA out Vdd pfet w=19 l=2
+  ad=209 pd=98 as=95 ps=48
M1002 out inA gnd Gnd nfet w=4 l=2
+  ad=0 pd=0 as=60 ps=44
M1003 K1 inC vdd Vdd pfet w=19 l=2
+  ad=0 pd=0 as=114 ps=50
M1004 vdd inB K1 Vdd pfet w=19 l=2
+  ad=0 pd=0 as=0 ps=0
M1005 gnd inC K2 Gnd nfet w=8 l=2
+  ad=0 pd=0 as=0 ps=0
C0 gnd Gnd 3.38fF
C1 K1 Gnd 4.51fF
C2 out Gnd 8.86fF
C3 inC Gnd 10.64fF
C4 inB Gnd 10.64fF
C5 inA Gnd 11.59fF
C6 vdd Gnd 3.01fF

*edo tha ginetai i allagi ton timon eisodou gia na epalitheusoume ton pinaka alithias tis sinartisis
Vin1 inA 0 PULSE(2.5 0 0 1p 1p 50n 100n)
Vin2 inB 0 PULSE(2.5 0 0 1p 1p 25n 50n)
Vin3 inC 0 PULSE(2.5 0 0 1p 1p 12.5n 25n)

* DATE: Jun 11/01
* LOT: T14Y                  WAF: 03
* DIE: N_Area_Fring          DEV: N3740/10
* Temp= 27
.MODEL nfet NMOS (                                 LEVEL  = 3
+ TOX    = 5.7E-9          NSUB   = 1E17            GAMMA  = 0.4317311
+ PHI    = 0.7             VTO    = 0.4238252       DELTA  = 0
+ UO     = 425.6466519     ETA    = 0               THETA  = 0.1754054
+ KP     = 2.501048E-4     VMAX   = 8.287851E4      KAPPA  = 0.1686779
+ RSH    = 4.062439E-3     NFS    = 1E12            TPG    = 1
+ XJ     = 3E-7            LD     = 3.162278E-11    WD     = 1.232881E-8
+ CGDO   = 6.2E-10         CGSO   = 6.2E-10         CGBO   = 1E-10
+ CJ     = 1.81211E-3      PB     = 0.5             MJ     = 0.3282553
+ CJSW   = 5.341337E-10    MJSW   = 0.5             )

.MODEL pfet PMOS (                                 LEVEL  = 3
+ TOX    = 5.7E-9          NSUB   = 1E17            GAMMA  = 0.6348369
+ PHI    = 0.7             VTO    = -0.5536085      DELTA  = 0
+ UO     = 250             ETA    = 0               THETA  = 0.1573195
+ KP     = 5.194153E-5     VMAX   = 2.295325E5      KAPPA  = 0.7448494
+ RSH    = 30.0776952      NFS    = 1E12            TPG    = -1
+ XJ     = 2E-7            LD     = 9.968346E-13    WD     = 5.475113E-9
+ CGDO   = 6.66E-10        CGSO   = 6.66E-10        CGBO   = 1E-10
+ CJ     = 1.893569E-3     PB     = 0.9906013       MJ     = 0.4664287
+ CJSW   = 3.625544E-10    MJSW   = 0.5             )
*

.tran 10p 100n
.control
 run
plot V(inA) V(inB) V(inC)  out

.endc
.end
