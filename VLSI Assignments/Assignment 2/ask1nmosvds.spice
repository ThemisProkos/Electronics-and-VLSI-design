.include ./technology.txt

Vgs 1 0 DC 2.5
Vds 2 0 DC 0
MNMOS 2 1 0 0 CMOSN W=3u L=2u

.DC Vds 0 2.5 0.25 Vgs 0 2.5 0.25
.control
	run
	set color0=black
	set color1=blue
	plot (-i(Vds))

.endc
.end
