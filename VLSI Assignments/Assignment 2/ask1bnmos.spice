.include ./technology.txt

Vgs 1 0 DC 2.5

C 2 0 0.1p
MNMOS 2 1 0 0 CMOSN W=3u L=2u

.IC v(2)=2.5
.measure tran tp WHEN v(2)=1.25 CROSS=1
.tran 1n 5n

.control
	run
	set color0=black
	set color1=blue
	plot V(2) 1.25

.endc
.end
