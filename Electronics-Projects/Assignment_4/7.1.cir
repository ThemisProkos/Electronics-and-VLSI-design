*Inverter power dissipation
M1 2 1 0 0 NMOS W={W1} L=0.25u AD={W1*Ld} AS={W1*Ld} PD={2*Ld+W1} PS={2*Ld+W1}
M2 2 1 3 3 PMOS W={4.81*W1} L=0.25u AD={4.81*W1*Ld} AS={4.81*W1*Ld} PD={2*Ld+4.81*W1} PS={2*Ld+4.81*W1}
CLx 2 0 0.1p
Vdd 3 0 DC 2.5
Vin 1 0 PULSE (2.5 0 0 7.5n 7.5n 10n 30n)

.TRAN 0.001n 30n
.MEASURE TRAN integ_I INTEG -I(Vdd)
.MEASURE paroxi param integ_I*2.5
.MEASURE isxui param integ_I*2.5/30n
.PROBE V(1) V(2) I(Vdd) Vdd
.PARAMS W1=1u,Ld=5u
.INC "tsmc025.sp"
.END
