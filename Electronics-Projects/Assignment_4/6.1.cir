*NAND2 propagation delay
M1 4 1 3 0 NMOS W={W1} L=0.25u AD={W1*Ld} AS={W1*Ld} PD={2*Ld+W1} PS={2*Ld+W1}
M2 3 2 0 0 NMOS W={W1} L=0.25u AD={W1*Ld} AS={W1*Ld} PD={2*Ld+W1} PS={2*Ld+W1}
M3 4 1 5 5 PMOS W={Wp} L=0.25u AD={Wp*Ld} AS={Wp*Ld} PD={2*Ld+Wp} PS{2*Ld+Wp}
M4 4 2 5 5 PMOS W={Wp} L=0.25u AD={Wp*Ld} AS={Wp*Ld} PD={2*Ld+Wp} PS{2*Ld+Wp}
CLx 4 0 0.2f
Vdd 5 0 DC 2.5

*to tplh apo (1,1)->(0,0)  */

*VinA 1 0 PULSE (2.5 0 1n 1.5n 1.5n 2.5n 10n)
*VinB 2 0 PULSE (2.5 0 1n 1.5n 1.5n 2.5n 10n)

*to tphl apo (0,0)->(1,1) to pull down network einai afortisto
*VinA 1 0 PULSE (0 2.5 1n 1.5n 1.5n 2.5n 10n)
*VinB 2 0 PULSE (0 2.5 1n 1.5n 1.5n 2.5n 10n)

*/to tplh apo (1,1)->(1,0)  */
*VinA 1 0 DC 2.5
*VinB 2 0 PULSE (2.5 0 1n 1.5n 1.5n 2.5n 10n)

*to tphl apo (1,0)->(1,1)
*VinA 1 0 DC 2.5
*VinB 2 0 PULSE (0 2.5 1n 1.5n 1.5n 2.5n 10n)

*to tplh apo (1,1)->(0,1)   */
*VinA 1 0 PULSE (2.5 0 1n 1.5n 1.5n 2.5n 10n)
*VinB 2 0 DC 2.5

*to tphl apo (0,1)->(1,1)

*VinA 1 0 PULSE (0 2.5 1n 1.5n 1.5n 2.5n 10n)
*VinB 2 0 DC 2.5

*to tphl (0,0)->(1,1)
*VinA 1 0 PULSE (0 2.5 1n 1.5n 1.5n 2.5n 10n)
*VinB 2 0 PULSE (0 2.5 1n 1.5n 1.5n 2.5n 10n)

*fortisi puknoti (1,0)->(0,0)->(1,1)
VinA 1 0 PULSE(2.5 0 1n 1.5n 1.5n 2.5n 10n)
Vinb 2 0 PULSE(0 2.5 5n 1.5n 1.5n 2.5n  10n)

.PARAMS W1=2u, Ld=5u,Wp=4.81u
.INC "tsmc025.sp"
.TRAN 0.001n 10n
.PROBE V(1) V(2) V(4) V(3)
.END
