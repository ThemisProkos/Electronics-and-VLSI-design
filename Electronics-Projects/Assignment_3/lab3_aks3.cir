*Interconnection delay analysis

*N=1
R1 1 2 {R}
C1 2 0 {C}

*N=2

R2 1 3 {R/2}
R3 3 4 {R/2}
C2 1 0 {C/4}
C3 3 0 {C/2}
C4 4 0 {C/4}

*N=3

R4 1 5 {R/3}
R5 5 6 {R/3}
R6 6 7 {R/3}
C5 1 0 {C/6}
C6 5 0 {C/3}
C7 6 0 {C/3}
C8 7 0 {C/6}

*N=4

R7 1 8 {R/4}
R8 8 9 {R/4}
R9 9 10 {R/4}
R10 10 11 {R/4}
C9 1 0 {C/8}
C10 8 0 {C/4}
C11 9 0 {C/4}
C12 10 0 {C/4}
C13 11 0 {C/8}

*N=5

R11 1 12 {R/5}
R12 12 13 {R/5}
R13 13 14 {R/5}
R14 14 15 {R/5}
R15 15 16 {R/5}
C14  1 0 {C/10}
C15 12 0 {C/5}
C16 13 0 {C/5}
C17 14 0 {C/5}
C18 15 0 {C/5}
C19 16 0 {C/10}

Vin 1 0 PULSE (0 3 20n 1p 1p 30n 80n)

.PARAM R=7.5k,C=0.356p
.TRAN 0.001n 80n
.END
